* Voltage divider — mid = 2.5 V
V1 in 0 10
R1 in mid 3k
R2 mid 0 1k
.op
.end
