* Resistor flicker noise (KF) + thermal
R1 in out 1k KF=1e-12
R2 out 0 1k
V1 in 0 1 AC 1
.noise V(out) V1 dec 5 10 1k
.end
