* RC discharge check — after long time out→0 from IC via DC OP of pulse=0 start
* Use step and check mid-time
V1 in 0 PULSE(0 1 0 1n 1n 1 2)
R1 in out 2k
C1 out 0 1u
.tran 50u 10m
.end
