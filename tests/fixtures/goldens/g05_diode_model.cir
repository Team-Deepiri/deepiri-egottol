* Diode with .model — Va in forward silicon range
V1 in 0 5
R1 in a 1k
D1 a 0 D1N4148
.model D1N4148 D (IS=2.52n N=1.752)
.op
.end
