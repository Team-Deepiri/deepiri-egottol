* LED + series current-limit (mandatory)
V1 in 0 5
Rlim in led 330
D1 led 0
.model D1 D (IS=1e-14 N=1)
.op
.end
