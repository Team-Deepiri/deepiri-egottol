* RC high-pass (AC couple / crossover style)
V1 in 0 AC 1
C1 in mid 100n
R1 mid 0 1k
.ac dec 20 10 1Meg
.end
