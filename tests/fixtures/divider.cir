* Voltage divider — CLI smoke circuit
V1 in 0 5
R1 in mid 1k
R2 mid 0 1k
.op
.end
