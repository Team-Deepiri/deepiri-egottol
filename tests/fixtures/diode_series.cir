* Diode series with resistor
V1 in 0 5
R1 in a 1k
D1 a 0 DMOD
.model DMOD D (Is=1e-14 N=1)
.op
.end
